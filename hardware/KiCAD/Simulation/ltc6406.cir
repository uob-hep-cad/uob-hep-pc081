.subckt LTC6406 INN VOCM VP OUTP OUTN VN SHDN INP OUTFN OUTFP
M1 OUTP N+ VN VN NI temp=27
D5 N+ VN DLIMN
M2 OUTP P+ VP VP PI temp=27
D8 VP P+ DLIMP
C3 VP P+ .1f Rser=4Meg noiseless
A3 N008 N010 VN VN VN VN P+ VN OTA g=200n ref=-55m linear vlow=-1e308 vhigh=1e308
A5 N006 0 N008 N008 N008 N008 N010 N008 OTA g=22u linear cout=1f Vhigh=1e308 Vlow=-1e308
G1 VN N+ N010 N008 200n
D9 N010 N008 DLIM
C7 VP INP 1p Rser=80 Rpar=200k noiseless
C13 VP VN 1000p
S1 N010 N008 0 N007 SHUT2
C17 VN SHDN 500f
S4 P+ VP 0 N007 SHUT1
S2 VN N+ 0 N007 SHUT1
A2 SHDN VP 0 0 0 0 N007 0 SCHMITT trise=150n tfall=40n vt=-1 vh=10m
D6 INN VP DESD
D7 VN INN DESD
D10 INP INN DIN
D11 VN INP DESD
A1 0 INP 0 0 0 0 0 0 OTA g=0 in=2.3p ink=91k
M3 OUTN N- VN VN NI temp=27
D3 N- VN DLIMN
M4 OUTN P- VP VP PI temp=27
D12 VP P- DLIMP
A6 N008 N021 VN VN VN VN P- VN OTA g=200n ref=-55m linear vlow=-1e308 vhigh=1e308
A7 0 N006 N008 N008 N008 N008 N021 N008 OTA g=22u linear cout=1f Vhigh=1e308 Vlow=-1e308
G5 VN N- N021 N008 200n
D13 N021 N008 DLIM
S3 N021 N008 0 N007 SHUT2
S5 P- VP 0 N007 SHUT1
S6 VN N- 0 N007 SHUT1
R3 OUTP OUTN 2Meg noiseless
G6 N008 N021 0 N012 20µ
G7 N008 N010 0 N012 20µ
D14 N012 0 DCML
C2 VP OUTP .1p Rpar=1Meg noiseless
C8 OUTP VN .1p Rpar=1Meg noiseless
C9 VP OUTN .1p Rpar=1Meg noiseless
C11 OUTN VN .1p Rpar=1Meg noiseless
C14 N010 OUTP 8f Rser=10k noiseless
C16 OUTN N021 8f Rser=10k noiseless
R10 VP SHDN 100k noiseless
D2 VP VN DPOWS
S7 VN VP N007 0 SPOWR
A10 0 INN 0 0 0 0 0 0 OTA g=0 in=2.4p ink=54k
D1 VOCM VP DESD
D4 VN VOCM DESD
D17 SHDN VP DESD
D18 VN SHDN DESD
B1 0 N005 I=10u*dnlim(uplim(V(INP),V(VP)+.3,.1), V(VN)-.3, .1)+1n*V(INP)
B2 N005 0 I=10u*dnlim(uplim(V(INN),V(VP)+.31,.1), V(VN)-.31, .1)+1n*V(INN)
C20 N005 0 .6f Rpar=100K noiseless
G8 0 N008 VN 0 .5m
G9 0 N008 VP 0 .5m
C21 N008 0 200p Rpar=1K noiseless
R5 OUTP OUTFP 50
C24 OUTFP OUTFN 1.25p
R6 OUTFN OUTN 50
C18 OUTFP VN 1.25p
C29 OUTFN VN 1.25p
C4 VP INN 1p Rser=80 Rpar=200k noiseless
C5 INP VN 1p Rser=80 Rpar=300k noiseless
C6 INN VN 1p Rser=80 Rpar=300k noiseless
D16 INP VP DESD
C1 P+ OUTP .01f Rser=20Meg noiseless
C22 OUTP N+ .01f Rser=20Meg noiseless
C23 P- OUTN .01f Rser=20Meg noiseless
C25 OUTN N- .01f Rser=20Meg noiseless
C12 N+ VN .1f Rser=4Meg noiseless
C15 VP P- .1f Rser=4Meg noiseless
C19 N- VN .1f Rser=4Meg noiseless
R9 VOCM VN 30.714k
R11 VP VOCM 43k
S8 INN VP N007 0 SBIAS
S9 INP VP N007 0 SBIAS
A4 0 N005 0 0 0 0 N006 0 OTA g=125u linear en=1.59n enk=8.1k Vhigh=1e308 Vlow=-1e308
D15 N006 0 DSI temp=27
D19 0 N006 DSI temp=27
S10 VP P+ OUTP VP SUPLIM
S11 VP P- OUTN VP SUPLIM
S12 N+ VN VN OUTP SDWLIM
S13 N- VN VN OUTN SDWLIM
A8 0 N020 0 0 0 0 N012 0 OTA g=8m iout=300u en=9.5n enk=18k Rout=1k ref=-6.6m Vlow=-1e308 Vhigh=1e308
C26 N012 0 1.8p Rser=200 noiseless
C10 N006 0 11.79f Rser=90k Rpar=60k noiseless
B3 0 N020 I=10u*dnlim(uplim(V(VOCM),V(VP)-.9,.1), V(VN)+.42, .1)
B4 N020 0 I=5u*(V(OUTP)+V(OUTN))
C27 N020 0 .1f Rpar=100K noiseless
.model DPOWS D(Ron=1k Roff=1G Vfwd=2 epsilon=.1 ilimit=117u noiseless)
.model SPOWR SW(level=1 Ron=100 Roff=1g vt=.5 vh=-.1 ilimit=16.3m noiseless)
.model SBIAS SW(level=2 Ron=10k Roff=1G vt=.5 vh=-.1 ilimit=3u Vser=-.2  noiseless)
.model DIN D(Ron=100 Roff=3k Vfwd=1.4 epsilon=.1 Vrev=1.4 epsilon=.1 noiseless)
.model SHUT1 SW(Ron=100k Roff=100G vt=-.8 vh=-100m Vser=300m noiseless)
.model SHUT2 SW(Ron=1k Roff=100G vt=-.8 vh=-100m noiseless)
.model SUPLIM SW(Ron=1k Roff=1G vt=-720m vh=-50m noiseless)
.model SDWLIM SW(Ron=1Meg Roff=1G vt=-241m vh=-50m noiseless)
.model NI VDMOS(Vto=300m kp=30m lambda=.1)
.model PI VDMOS(Vto=-300m Kp=30m lambda=.1 pchan)
.model DLS D(Ron=10k Roff=1G Vfwd=.4 Vrev=.4 epsilon=50m revepsilon=50m noiseless)
.model DLIMN D(Ron=100k Roff=100Meg Vfwd=1.9 Vrev=-300m epsilon=.1  noiseless)
.model DLIMP D(Ron=100k Roff=100Meg Vfwd=1.9 Vrev=-300m  epsilon=10m revepsilon=10m noiseless)
.model DCML D(Ron=10 Roff=1k Vfwd=500m epsilon=10m Vrev=500m revepsilon=10m noiseless)
.model DLIM D(Ron=100 Roff=52k Vfwd=2 Vrev=2 epsilon=100m revepsilon=100m noiseless)
.model DSI D(IS=2e-8 TT=5e-10 noiseless)
.model DESD D(Ron=100 Roff=1G Vfwd=.7 epsilon=.1 noiseless)
.ends LTC6406
*
