.subckt LTC6406 1 2 3 4 5 6 7 8 9 10
M1 4 N+ 6 6 NI temp=27
D5 N+ 6 DLIMN
M2 4 P+ 3 3 PI temp=27
D8 3 P+ DLIMP
C3 3 P+ .1f Rser=4Meg noiseless
A3 N008 N010 6 6 6 6 P+ 6 OTA g=200n ref=-55m linear vlow=-1e308 vhigh=1e308
A5 N006 0 N008 N008 N008 N008 N010 N008 OTA g=22u linear cout=1f Vhigh=1e308 Vlow=-1e308
G1 6 N+ N010 N008 200n
D9 N010 N008 DLIM
C7 3 8 1p Rser=80 Rpar=200k noiseless
C13 3 6 1000p
S1 N010 N008 0 N007 SHUT2
C17 6 7 500f
S4 P+ 3 0 N007 SHUT1
S2 6 N+ 0 N007 SHUT1
A2 7 3 0 0 0 0 N007 0 SCHMITT trise=150n tfall=40n vt=-1 vh=10m
D6 1 3 DESD
D7 6 1 DESD
D10 8 1 DIN
D11 6 8 DESD
A1 0 8 0 0 0 0 0 0 OTA g=0 in=2.3p ink=91k
M3 5 N- 6 6 NI temp=27
D3 N- 6 DLIMN
M4 5 P- 3 3 PI temp=27
D12 3 P- DLIMP
A6 N008 N021 6 6 6 6 P- 6 OTA g=200n ref=-55m linear vlow=-1e308 vhigh=1e308
A7 0 N006 N008 N008 N008 N008 N021 N008 OTA g=22u linear cout=1f Vhigh=1e308 Vlow=-1e308
G5 6 N- N021 N008 200n
D13 N021 N008 DLIM
S3 N021 N008 0 N007 SHUT2
S5 P- 3 0 N007 SHUT1
S6 6 N- 0 N007 SHUT1
R3 4 5 2Meg noiseless
G6 N008 N021 0 N012 20µ
G7 N008 N010 0 N012 20µ
D14 N012 0 DCML
C2 3 4 .1p Rpar=1Meg noiseless
C8 4 6 .1p Rpar=1Meg noiseless
C9 3 5 .1p Rpar=1Meg noiseless
C11 5 6 .1p Rpar=1Meg noiseless
C14 N010 4 8f Rser=10k noiseless
C16 5 N021 8f Rser=10k noiseless
R10 3 7 100k noiseless
D2 3 6 DPOWS
S7 6 3 N007 0 SPOWR
A10 0 1 0 0 0 0 0 0 OTA g=0 in=2.4p ink=54k
D1 2 3 DESD
D4 6 2 DESD
D17 7 3 DESD
D18 6 7 DESD
B1 0 N005 I=10u*dnlim(uplim(V(8),V(3)+.3,.1), V(6)-.3, .1)+1n*V(8)
B2 N005 0 I=10u*dnlim(uplim(V(1),V(3)+.31,.1), V(6)-.31, .1)+1n*V(1)
C20 N005 0 .6f Rpar=100K noiseless
G8 0 N008 6 0 .5m
G9 0 N008 3 0 .5m
C21 N008 0 200p Rpar=1K noiseless
R5 4 10 50
C24 10 9 1.25p
R6 9 5 50
C18 10 6 1.25p
C29 9 6 1.25p
C4 3 1 1p Rser=80 Rpar=200k noiseless
C5 8 6 1p Rser=80 Rpar=300k noiseless
C6 1 6 1p Rser=80 Rpar=300k noiseless
D16 8 3 DESD
C1 P+ 4 .01f Rser=20Meg noiseless
C22 4 N+ .01f Rser=20Meg noiseless
C23 P- 5 .01f Rser=20Meg noiseless
C25 5 N- .01f Rser=20Meg noiseless
C12 N+ 6 .1f Rser=4Meg noiseless
C15 3 P- .1f Rser=4Meg noiseless
C19 N- 6 .1f Rser=4Meg noiseless
R9 2 6 30.714k
R11 3 2 43k
S8 1 3 N007 0 SBIAS
S9 8 3 N007 0 SBIAS
A4 0 N005 0 0 0 0 N006 0 OTA g=125u linear en=1.59n enk=8.1k Vhigh=1e308 Vlow=-1e308
D15 N006 0 DSI temp=27
D19 0 N006 DSI temp=27
S10 3 P+ 4 3 SUPLIM
S11 3 P- 5 3 SUPLIM
S12 N+ 6 6 4 SDWLIM
S13 N- 6 6 5 SDWLIM
A8 0 N020 0 0 0 0 N012 0 OTA g=8m iout=300u en=9.5n enk=18k Rout=1k ref=-6.6m Vlow=-1e308 Vhigh=1e308
C26 N012 0 1.8p Rser=200 noiseless
C10 N006 0 11.79f Rser=90k Rpar=60k noiseless
B3 0 N020 I=10u*dnlim(uplim(V(2),V(3)-.9,.1), V(6)+.42, .1)
B4 N020 0 I=5u*(V(4)+V(5))
C27 N020 0 .1f Rpar=100K noiseless
.model DPOWS D(Ron=1k Roff=1G Vfwd=2 epsilon=.1 ilimit=117u noiseless)
.model SPOWR SW(level=1 Ron=100 Roff=1g vt=.5 vh=-.1 ilimit=16.3m noiseless)
.model SBIAS SW(level=2 Ron=10k Roff=1G vt=.5 vh=-.1 ilimit=3u Vser=-.2  noiseless)
.model DIN D(Ron=100 Roff=3k Vfwd=1.4 epsilon=.1 Vrev=1.4 epsilon=.1 noiseless)
.model SHUT1 SW(Ron=100k Roff=100G vt=-.8 vh=-100m Vser=300m noiseless)
.model SHUT2 SW(Ron=1k Roff=100G vt=-.8 vh=-100m noiseless)
.model SUPLIM SW(Ron=1k Roff=1G vt=-720m vh=-50m noiseless)
.model SDWLIM SW(Ron=1Meg Roff=1G vt=-241m vh=-50m noiseless)
.model NI VDMOS(Vto=300m kp=30m lambda=.1)
.model PI VDMOS(Vto=-300m Kp=30m lambda=.1 pchan)
.model DLS D(Ron=10k Roff=1G Vfwd=.4 Vrev=.4 epsilon=50m revepsilon=50m noiseless)
.model DLIMN D(Ron=100k Roff=100Meg Vfwd=1.9 Vrev=-300m epsilon=.1  noiseless)
.model DLIMP D(Ron=100k Roff=100Meg Vfwd=1.9 Vrev=-300m  epsilon=10m revepsilon=10m noiseless)
.model DCML D(Ron=10 Roff=1k Vfwd=500m epsilon=10m Vrev=500m revepsilon=10m noiseless)
.model DLIM D(Ron=100 Roff=52k Vfwd=2 Vrev=2 epsilon=100m revepsilon=100m noiseless)
.model DSI D(IS=2e-8 TT=5e-10 noiseless)
.model DESD D(Ron=100 Roff=1G Vfwd=.7 epsilon=.1 noiseless)
.ends LTC6406
*
